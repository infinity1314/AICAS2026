* NMCNR 单文件对照实验（用于定位 pipeline vs NMCMR1 差异）
* 目标：尽量复刻 NMCMR1.cir 的顶层连接方式，但子电路内容使用 pipeline 生成的数值版 NMCNR.cir
*
* 运行（从项目根）：
*   ngspice -b scene2/sim_NMCNR/NMCNR_SINGLE_pdk.cir

.option ngbehavior=ltpsa
.lib 'scene2/models/sky130.lib.spice' tt
.TEMP 25

.PARAM
+ VDD_VAL=1.8
+ VCM_VAL=0.9
+ CLOAD=10p

* 与 NMCMR1 一致：实例名 XX1，端口 (0 vdd vinn vinp vout)
XX1 0 vdd vinn vinp vout Leung_NMCNR_Pin_3

* 子电路直接 include，避免此文件内容过期
.include 'scene2/sim_NMCNR/NMCNR.cir'

* ========= 顶层偏置/激励（尽量与 NMCMR1 一致）=========
VDD_SRC vdd_src 0 'VDD_VAL'
VMEAS vdd_src vdd 0

VCM_IN vinp 0 'VCM_VAL'
VAC vinn vinp DC 0 AC 1

CL vout 0 'CLOAD'

.control
  set filetype=ascii
  set units=degrees
  op
  print i(vmeas) > Idc_single.txt
  ac dec 100 1 1000Meg
  meas ac gain_max find vdb(vout) at=1
  meas ac gbw when vdb(vout)=0
  meas ac phase_margin find vp(vout) when vdb(vout)=0
  echo "Gain= $&gain_max" >  AC_results_single.txt
  echo "GBW= $&gbw"       >> AC_results_single.txt
  echo "PM= $&phase_margin" >> AC_results_single.txt
.endc

.end
