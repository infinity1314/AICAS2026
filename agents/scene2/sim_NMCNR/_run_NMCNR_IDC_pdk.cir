* Leung NMCNR 三级放大器 - 性能指标自动输出版
.lib "/home/jzhuang/AnalogLLM/AICAS4Analog/scene2/models/sky130.lib.spice" tt

.PARAM
+ CURRENT_0_BIAS=5.0u
+ VDD_VAL=1.8
+ VCM_VAL=0.9
+ CLOAD=10p
+ MOSFET_0_8_L_BIASCM_PMOS=2.0
+ MOSFET_0_8_W_BIASCM_PMOS=1.8152
+ MOSFET_0_8_M_BIASCM_PMOS=4
+ MOSFET_8_2_L_gm1_PMOS=2.0
+ MOSFET_8_2_W_gm1_PMOS=3.8236
+ MOSFET_8_2_M_gm1_PMOS=4
+ MOSFET_10_1_L_gm2_PMOS=1.45
+ MOSFET_10_1_W_gm2_PMOS=2.692
+ MOSFET_10_1_M_gm2_PMOS=4
+ MOSFET_23_1_L_gm3_NMOS=2.0
+ MOSFET_23_1_W_gm3_NMOS=0.7505
+ MOSFET_23_1_M_gm3_NMOS=4
+ MOSFET_17_7_L_BIASCM_NMOS=0.9
+ MOSFET_17_7_W_BIASCM_NMOS=0.6693
+ MOSFET_17_7_M_BIASCM_NMOS=16
+ MOSFET_21_2_L_LOAD2_NMOS=1.5
+ MOSFET_21_2_W_LOAD2_NMOS=19.5731
+ MOSFET_21_2_M_LOAD2_NMOS=4
+ RESISTOR_0=15k
+ CAPACITOR_0=0.4p
+ CAPACITOR_1=0.2p

* --- 第一级 ---
+ MOSFET_8_2_L_gm1_PMOS=1.93
+ MOSFET_8_2_W_gm1_PMOS=4.0
+ MOSFET_8_2_M_gm1_PMOS=4

* --- 第二级 ---
+ MOSFET_10_1_L_gm2_PMOS=1.44
+ MOSFET_10_1_W_gm2_PMOS=3.2
+ MOSFET_10_1_M_gm2_PMOS=4

* --- 第三级 (微调W到1.7，扶正输出电平以提升带宽) ---
+ MOSFET_23_1_L_gm3_NMOS=1.9
+ MOSFET_23_1_W_gm3_NMOS=0.75
+ MOSFET_23_1_M_gm3_NMOS=4

* --- 偏置网络 ---
+ MOSFET_0_8_L_BIASCM_PMOS=2.0
+ MOSFET_0_8_W_BIASCM_PMOS=2.3
+ MOSFET_0_8_M_BIASCM_PMOS=4
+ MOSFET_17_7_L_BIASCM_NMOS=0.9
+ MOSFET_17_7_W_BIASCM_NMOS=0.47
+ MOSFET_17_7_M_BIASCM_NMOS=4
+ MOSFET_21_2_L_LOAD2_NMOS=1.5
+ MOSFET_21_2_W_LOAD2_NMOS=2.0
+ MOSFET_21_2_M_LOAD2_NMOS=4

* --- 补偿元件 ---
+ RESISTOR_0=15k
+ CAPACITOR_0=0.4p
+ CAPACITOR_1=0.2p

XX1 0 vdd vinn vinp vout Leung_NMCNR_Pin_3

.subckt Leung_NMCNR_Pin_3 gnda vdda vinn vinp vout
xm11 VOUT net013 vdda vdda sky130_fd_pr__pfet_01v8_lvt l='MOSFET_0_8_L_BIASCM_PMOS' w='MOSFET_0_8_W_BIASCM_PMOS' m='MOSFET_0_8_M_BIASCM_PMOS*10'
xm7 net049 net013 vdda vdda sky130_fd_pr__pfet_01v8_lvt l='MOSFET_0_8_L_BIASCM_PMOS' w='MOSFET_0_8_W_BIASCM_PMOS' m='MOSFET_0_8_M_BIASCM_PMOS'
xm10 net043 net050 vdda vdda sky130_fd_pr__pfet_01v8_lvt l='MOSFET_10_1_L_gm2_PMOS' w='MOSFET_10_1_W_gm2_PMOS' m='MOSFET_10_1_M_gm2_PMOS'
xm6 net050 VOUTN vdda vdda sky130_fd_pr__pfet_01v8_lvt l='MOSFET_0_8_L_BIASCM_PMOS' w='MOSFET_0_8_W_BIASCM_PMOS' m='MOSFET_0_8_M_BIASCM_PMOS'
xm5 VOUTN VOUTN vdda vdda sky130_fd_pr__pfet_01v8_lvt l='MOSFET_0_8_L_BIASCM_PMOS' w='MOSFET_0_8_W_BIASCM_PMOS' m='MOSFET_0_8_M_BIASCM_PMOS'
xm9 net063 vinp net31 net31 sky130_fd_pr__pfet_01v8_lvt l='MOSFET_8_2_L_gm1_PMOS' w='MOSFET_8_2_W_gm1_PMOS' m='MOSFET_8_2_M_gm1_PMOS'
xm8 DM_2 vinn net31 net31 sky130_fd_pr__pfet_01v8_lvt l='MOSFET_8_2_L_gm1_PMOS' w='MOSFET_8_2_W_gm1_PMOS' m='MOSFET_8_2_M_gm1_PMOS'
xm4 net31 net013 vdda vdda sky130_fd_pr__pfet_01v8_lvt l='MOSFET_0_8_L_BIASCM_PMOS' w='MOSFET_0_8_W_BIASCM_PMOS' m='4*MOSFET_0_8_M_BIASCM_PMOS'
xm3 VB3 net013 vdda vdda sky130_fd_pr__pfet_01v8_lvt l='MOSFET_0_8_L_BIASCM_PMOS' w='MOSFET_0_8_W_BIASCM_PMOS' m='MOSFET_0_8_M_BIASCM_PMOS'
xm2 DM_1 net013 vdda vdda sky130_fd_pr__pfet_01v8_lvt l='MOSFET_0_8_L_BIASCM_PMOS' w='MOSFET_0_8_W_BIASCM_PMOS' m='MOSFET_0_8_M_BIASCM_PMOS'
xm1 VB4 net013 vdda vdda sky130_fd_pr__pfet_01v8_lvt l='MOSFET_0_8_L_BIASCM_PMOS' w='MOSFET_0_8_W_BIASCM_PMOS' m='MOSFET_0_8_M_BIASCM_PMOS'
xm0 net013 net013 vdda vdda sky130_fd_pr__pfet_01v8_lvt l='MOSFET_0_8_L_BIASCM_PMOS' w='MOSFET_0_8_W_BIASCM_PMOS' m='MOSFET_0_8_M_BIASCM_PMOS'

xm23 VOUT net049 gnda gnda sky130_fd_pr__nfet_01v8 l='MOSFET_23_1_L_gm3_NMOS' w='MOSFET_23_1_W_gm3_NMOS' m='MOSFET_23_1_M_gm3_NMOS'
xm22 net049 net043 gnda gnda sky130_fd_pr__nfet_01v8 l='MOSFET_21_2_L_LOAD2_NMOS' w='MOSFET_21_2_W_LOAD2_NMOS' m='MOSFET_21_2_M_LOAD2_NMOS'
xm21 net043 net043 gnda gnda sky130_fd_pr__nfet_01v8 l='MOSFET_21_2_L_LOAD2_NMOS' w='MOSFET_21_2_W_LOAD2_NMOS' m='MOSFET_21_2_M_LOAD2_NMOS'
xm19 DM_2 VB4 gnda gnda sky130_fd_pr__nfet_01v8 l='MOSFET_17_7_L_BIASCM_NMOS' w='MOSFET_17_7_W_BIASCM_NMOS' m='MOSFET_17_7_M_BIASCM_NMOS*8'
xm15 VOUTN VB3 DM_2 gnda sky130_fd_pr__nfet_01v8 l='MOSFET_17_7_L_BIASCM_NMOS' w='MOSFET_17_7_W_BIASCM_NMOS' m='MOSFET_17_7_M_BIASCM_NMOS*4'
xm20 net063 VB4 gnda gnda sky130_fd_pr__nfet_01v8 l='MOSFET_17_7_L_BIASCM_NMOS' w='MOSFET_17_7_W_BIASCM_NMOS' m='MOSFET_17_7_M_BIASCM_NMOS*8'
xm16 net050 VB3 net063 gnda sky130_fd_pr__nfet_01v8 l='MOSFET_17_7_L_BIASCM_NMOS' w='MOSFET_17_7_W_BIASCM_NMOS' m='MOSFET_17_7_M_BIASCM_NMOS*4'
xm17 net54 VB4 gnda gnda sky130_fd_pr__nfet_01v8 l='MOSFET_17_7_L_BIASCM_NMOS' w='MOSFET_17_7_W_BIASCM_NMOS' m='MOSFET_17_7_M_BIASCM_NMOS*4'
xm14 VB3 VB3 gnda gnda sky130_fd_pr__nfet_01v8 l='MOSFET_17_7_L_BIASCM_NMOS' w='MOSFET_17_7_W_BIASCM_NMOS' m='MOSFET_17_7_M_BIASCM_NMOS'
xm12 VB4 VB3 net54 gnda sky130_fd_pr__nfet_01v8 l='MOSFET_17_7_L_BIASCM_NMOS' w='MOSFET_17_7_W_BIASCM_NMOS' m='MOSFET_17_7_M_BIASCM_NMOS*4'
xm18 net56 VB4 gnda gnda sky130_fd_pr__nfet_01v8 l='MOSFET_17_7_L_BIASCM_NMOS' w='MOSFET_17_7_W_BIASCM_NMOS' m='MOSFET_17_7_M_BIASCM_NMOS*4'
xm13 DM_1 VB3 net56 gnda sky130_fd_pr__nfet_01v8 l='MOSFET_17_7_L_BIASCM_NMOS' w='MOSFET_17_7_W_BIASCM_NMOS' m='MOSFET_17_7_M_BIASCM_NMOS*4'

I0 net013 gnda 'CURRENT_0_BIAS'
C1 net044 net049 'CAPACITOR_1'
C0 net050 net044 'CAPACITOR_0'
R0 net044 vout 'RESISTOR_0'
.ends

VDD_SRC vdd_src 0 dc=1.8
VMEAS vdd_src vdd 0
VCM_IN vinp 0 'VCM_VAL'
VAC vinn vinp DC 0 AC 1
CL vout 0 'CLOAD'

.op
.CONTROL
run
op
print i(vmeas) > Idc_1.txt
print @m.xx1.xm0.mmsky130_fd_pr__pfet_01v8_lvt[vds] @m.xx1.xm0.mmsky130_fd_pr__pfet_01v8_lvt[vgs] @m.xx1.xm0.mmsky130_fd_pr__pfet_01v8_lvt[vth] > Op_1.txt
print @m.xx1.xm1.mmsky130_fd_pr__pfet_01v8_lvt[vds] @m.xx1.xm1.mmsky130_fd_pr__pfet_01v8_lvt[vgs] @m.xx1.xm1.mmsky130_fd_pr__pfet_01v8_lvt[vth] >> Op_1.txt
print @m.xx1.xm2.mmsky130_fd_pr__pfet_01v8_lvt[vds] @m.xx1.xm2.mmsky130_fd_pr__pfet_01v8_lvt[vgs] @m.xx1.xm2.mmsky130_fd_pr__pfet_01v8_lvt[vth] >> Op_1.txt
print @m.xx1.xm3.mmsky130_fd_pr__pfet_01v8_lvt[vds] @m.xx1.xm3.mmsky130_fd_pr__pfet_01v8_lvt[vgs] @m.xx1.xm3.mmsky130_fd_pr__pfet_01v8_lvt[vth] >> Op_1.txt
print @m.xx1.xm4.mmsky130_fd_pr__pfet_01v8_lvt[vds] @m.xx1.xm4.mmsky130_fd_pr__pfet_01v8_lvt[vgs] @m.xx1.xm4.mmsky130_fd_pr__pfet_01v8_lvt[vth] >> Op_1.txt
print @m.xx1.xm5.mmsky130_fd_pr__pfet_01v8_lvt[vds] @m.xx1.xm5.mmsky130_fd_pr__pfet_01v8_lvt[vgs] @m.xx1.xm5.mmsky130_fd_pr__pfet_01v8_lvt[vth] >> Op_1.txt
print @m.xx1.xm6.mmsky130_fd_pr__pfet_01v8_lvt[vds] @m.xx1.xm6.mmsky130_fd_pr__pfet_01v8_lvt[vgs] @m.xx1.xm6.mmsky130_fd_pr__pfet_01v8_lvt[vth] >> Op_1.txt
print @m.xx1.xm7.mmsky130_fd_pr__pfet_01v8_lvt[vds] @m.xx1.xm7.mmsky130_fd_pr__pfet_01v8_lvt[vgs] @m.xx1.xm7.mmsky130_fd_pr__pfet_01v8_lvt[vth] >> Op_1.txt
print @m.xx1.xm8.mmsky130_fd_pr__pfet_01v8_lvt[vds] @m.xx1.xm8.mmsky130_fd_pr__pfet_01v8_lvt[vgs] @m.xx1.xm8.mmsky130_fd_pr__pfet_01v8_lvt[vth] >> Op_1.txt
print @m.xx1.xm9.mmsky130_fd_pr__pfet_01v8_lvt[vds] @m.xx1.xm9.mmsky130_fd_pr__pfet_01v8_lvt[vgs] @m.xx1.xm9.mmsky130_fd_pr__pfet_01v8_lvt[vth] >> Op_1.txt
print @m.xx1.xm10.mmsky130_fd_pr__pfet_01v8_lvt[vds] @m.xx1.xm10.mmsky130_fd_pr__pfet_01v8_lvt[vgs] @m.xx1.xm10.mmsky130_fd_pr__pfet_01v8_lvt[vth] >> Op_1.txt
print @m.xx1.xm11.mmsky130_fd_pr__pfet_01v8_lvt[vds] @m.xx1.xm11.mmsky130_fd_pr__pfet_01v8_lvt[vgs] @m.xx1.xm11.mmsky130_fd_pr__pfet_01v8_lvt[vth] >> Op_1.txt
print @m.xx1.xm12.msky130_fd_pr__nfet_01v8[vds] @m.xx1.xm12.msky130_fd_pr__nfet_01v8[vgs] @m.xx1.xm12.msky130_fd_pr__nfet_01v8[vth] >> Op_1.txt
print @m.xx1.xm13.msky130_fd_pr__nfet_01v8[vds] @m.xx1.xm13.msky130_fd_pr__nfet_01v8[vgs] @m.xx1.xm13.msky130_fd_pr__nfet_01v8[vth] >> Op_1.txt
print @m.xx1.xm14.msky130_fd_pr__nfet_01v8[vds] @m.xx1.xm14.msky130_fd_pr__nfet_01v8[vgs] @m.xx1.xm14.msky130_fd_pr__nfet_01v8[vth] >> Op_1.txt
print @m.xx1.xm15.msky130_fd_pr__nfet_01v8[vds] @m.xx1.xm15.msky130_fd_pr__nfet_01v8[vgs] @m.xx1.xm15.msky130_fd_pr__nfet_01v8[vth] >> Op_1.txt
print @m.xx1.xm16.msky130_fd_pr__nfet_01v8[vds] @m.xx1.xm16.msky130_fd_pr__nfet_01v8[vgs] @m.xx1.xm16.msky130_fd_pr__nfet_01v8[vth] >> Op_1.txt
print @m.xx1.xm17.msky130_fd_pr__nfet_01v8[vds] @m.xx1.xm17.msky130_fd_pr__nfet_01v8[vgs] @m.xx1.xm17.msky130_fd_pr__nfet_01v8[vth] >> Op_1.txt
print @m.xx1.xm18.msky130_fd_pr__nfet_01v8[vds] @m.xx1.xm18.msky130_fd_pr__nfet_01v8[vgs] @m.xx1.xm18.msky130_fd_pr__nfet_01v8[vth] >> Op_1.txt
print @m.xx1.xm19.msky130_fd_pr__nfet_01v8[vds] @m.xx1.xm19.msky130_fd_pr__nfet_01v8[vgs] @m.xx1.xm19.msky130_fd_pr__nfet_01v8[vth] >> Op_1.txt
print @m.xx1.xm20.msky130_fd_pr__nfet_01v8[vds] @m.xx1.xm20.msky130_fd_pr__nfet_01v8[vgs] @m.xx1.xm20.msky130_fd_pr__nfet_01v8[vth] >> Op_1.txt
print @m.xx1.xm21.msky130_fd_pr__nfet_01v8[vds] @m.xx1.xm21.msky130_fd_pr__nfet_01v8[vgs] @m.xx1.xm21.msky130_fd_pr__nfet_01v8[vth] >> Op_1.txt
print @m.xx1.xm22.msky130_fd_pr__nfet_01v8[vds] @m.xx1.xm22.msky130_fd_pr__nfet_01v8[vgs] @m.xx1.xm22.msky130_fd_pr__nfet_01v8[vth] >> Op_1.txt
print @m.xx1.xm23.msky130_fd_pr__nfet_01v8[vds] @m.xx1.xm23.msky130_fd_pr__nfet_01v8[vgs] @m.xx1.xm23.msky130_fd_pr__nfet_01v8[vth] >> Op_1.txt
.ENDC
.END
