* Minimal model for ngspice: subcircuit sky130_fd_pr__nfet_01v8 references this name.
* Use level 1 so no BSIM variables required; sufficient for topology to run.
.model sky130_fd_pr__nfet_01v8__model nmos level=1 kp=100e-6 vto=0.5
