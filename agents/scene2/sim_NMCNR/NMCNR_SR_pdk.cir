* Leung NMCNR OTA SR transient testbench（从项目根运行）
* 单独测试：
*   ngspice -b scene2/sim_NMCNR/NMCNR_SR_pdk.cir

.option ngbehavior=ltpsa
.lib 'scene2/models/sky130.lib.spice' tt
.include 'scene2/sim_NMCNR/NMCNR.cir'
.TEMP 25

* 供电/激励（与 NMCMR1 一致的 VDD/VCM；VINP 做阶跃，VINN 固定共模）
VVDD vdd 0 dc=1.8
VIP vinp 0 dc=0.9 pulse(0.9 1.3 0 1p 1p 5u 10u)
VIN vinn 0 dc=0.9

XX1 0 vdd vinn vinp vout Leung_NMCNR_Pin_3
CL vout 0 10e-12

.tran 0.2n 2u
.control
  run
  wrdata scene2/sim_NMCNR/SR_tran.txt time v(vout)
.endc
.end
