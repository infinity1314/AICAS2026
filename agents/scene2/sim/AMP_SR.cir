* OTA SR transient testbench, compact model; run from scene2/sim
.include 'sky130_compact.lib'
.include 'AMP.cir'

V1 VSS 0 dc=0
V0 VDD 0 dc=1.8

VIP Vinp 0 dc=0.9 pulse(0.9 1.3 0 1p 1p 5u 10u)
VIN Vinn 0 dc=0.9

XI1 Vinp Vinn VDD VSS Vout AMP
C1 Vout 0 2e-12

.tran 0.2n 2u

.CONTROL
run
write SR_tran.txt time v(vout)
.ENDC
.END
