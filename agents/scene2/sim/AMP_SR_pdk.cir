* OTA SR (slew rate) transient testbench, project PDK. Run from project root: ngspice -b scene2/sim/AMP_SR_pdk.cir
* Step input -> measure dVout/dt -> SR (V/us). Output: time and v(vout) to SR_tran.txt for post-processing.
.lib 'scene2/models/sky130.lib.spice' tt
.include 'scene2/sim/AMP.cir'

V1 VSS 0 dc=0
V0 VDD 0 dc=1.8

* Large differential step: Vinp 0.9 -> 1.3 at t=0 so output slews
VIP Vinp 0 dc=0.9 pulse(0.9 1.3 0 1p 1p 5u 10u)
VIN Vinn 0 dc=0.9

XI1 Vinp Vinn VDD VSS Vout AMP
C1 Vout 0 2e-12

.tran 0.2n 2u

.CONTROL
run
* ASCII two-column (time, v(vout)); path relative to project root so file lands in scene2/sim
wrdata scene2/sim/SR_tran.txt time v(vout)
.ENDC
.END
