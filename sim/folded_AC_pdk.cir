* Folded cascode OTA AC with project PDK (run from project root: ngspice -b scene2/sim/folded_AC_pdk.cir)
* 与套筒一致：使用 models/sky130.lib.spice
* PDK 子电路内部引用 __model（无 .0），但 pm3 只定义 __model.0，故需 include model alias 使 __model 指向 __model.0

* 1. 强制开启兼容模式（解决 ngspice 与 Sky130 PDK 兼容性问题）
.option ngbehavior=ltpsa

* 2. 补全 PDK 缺失的全局参数（解决 "could not find a valid modelname" 报错）
.param sky130_fd_pr__nfet_01v8__toxe_slope=0
.param sky130_fd_pr__nfet_01v8__vth0_slope=0
.param sky130_fd_pr__nfet_01v8__voff_slope=0
.param sky130_fd_pr__nfet_01v8__vth0_slope_spectre=1
.param sky130_fd_pr__nfet_01v8__voff_slope_spectre=1
.param sky130_fd_pr__pfet_01v8_lvt__toxe_slope=0
.param sky130_fd_pr__pfet_01v8_lvt__vth0_slope=0
.param sky130_fd_pr__pfet_01v8_lvt__voff_slope=0
.param sky130_fd_pr__pfet_01v8_lvt__vth0_slope_spectre=1
.param sky130_fd_pr__pfet_01v8_lvt__voff_slope_spectre=1
.param mult=1

.lib 'scene2/models/sky130.lib.spice' tt
.include 'scene2/sim/folded_nfet_model_alias.spice'
.include 'scene2/sim/folded_pfet_model_alias.spice'
.include 'scene2/sim/AMP.cir'
.TEMP 25.0

V1 VSS 0 dc=0
V0 VDD 0 dc=1.8
VIN Vinn 0 dc=0.9 ac=0.5
VIP Vinp 0 dc=0.9 ac=-0.5

XI1 Vinp Vinn VDD VSS Vout AMP_FOLDED
C1 Vout 0 2.1e-12

.ac dec 100 1 1000Meg
.print ac vdb(Vout) vp(Vout)

.CONTROL
set units=degrees
run
meas ac gain_max find vdb(Vout) at=1
meas ac gbw when vdb(Vout)=0
meas ac phase_margin find vp(Vout) when vdb(Vout)=0
echo "Gain= $&gain_max" > AC_results_1.txt
echo "GBW= $&gbw" >> AC_results_1.txt
echo "PM= $&phase_margin" >> AC_results_1.txt
.ENDC
.END
