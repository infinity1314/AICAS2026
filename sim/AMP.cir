.subckt AMP Vinp Vinn VDD VSS Vout
XM1 net2 Vinp net3 net3 sky130_fd_pr__nfet_01v8 L=0.385 W=6.96 m=10
XM2 net1 Vinn net3 net3 sky130_fd_pr__nfet_01v8 L=0.385 W=6.96 m=10
XM3 net4 vbn2 net2 net2 sky130_fd_pr__nfet_01v8 L=0.7 W=19.39
XM4 Vout vbn2 net1 net1 sky130_fd_pr__nfet_01v8 L=0.7 W=19.39
XM5 net4 vbp net6 net6 sky130_fd_pr__pfet_01v8_lvt L=1.15 W=5.55 m=10
XM6 Vout vbp net5 net5 sky130_fd_pr__pfet_01v8_lvt L=1.15 W=5.55 m=10
XM7 net6 net4 VDD VDD sky130_fd_pr__pfet_01v8_lvt L=1.125 W=5.55 m=10
XM8 net5 net4 VDD VDD sky130_fd_pr__pfet_01v8_lvt L=1.125 W=5.55 m=10
XM9 net3 vbn1 VSS VSS sky130_fd_pr__nfet_01v8 L=1.0 W=6.96 m=10
XSLM10 Vout net7 VDD VDD sky130_fd_pr__pfet_01v8_lvt L=0.5 W=5.0
XSLM11 net7 vbp1 VDD VDD sky130_fd_pr__pfet_01v8_lvt L=0.5 W=5.0
XSLM12 net7 net3 VSS VSS sky130_fd_pr__nfet_01v8 L=0.5 W=5.0
VBP vbp VSS dc=0.85
VBN2 vbn2 VSS dc=1.36
VBN1 vbn1 VSS dc=0.7
VSLBP1 vbp1 VSS dc=0.9
.ends AMP
