* minimal test: one M with __model.0
.include "/home/jzhuang/AnalogLLM/AICAS4Analog/cells/nfet_01v8/sky130_fd_pr__nfet_01v8__tt.pm3.spice"
VDD 1 0 1.8
M1 2 2 0 0 sky130_fd_pr__nfet_01v8__model.0 L=0.5 W=10
.op
.end
