* Leung NMCNR OTA IDC（从项目根运行，与 folded_AC 同序：.lib 再 .include alias 再 .include 电路）
.option ngbehavior=ltpsa
.param sky130_fd_pr__nfet_01v8__toxe_slope=0
.param sky130_fd_pr__nfet_01v8__vth0_slope=0
.param sky130_fd_pr__nfet_01v8__voff_slope=0
.param sky130_fd_pr__nfet_01v8__toxe_slope_spectre=1
.param sky130_fd_pr__nfet_01v8__vth0_slope_spectre=1
.param sky130_fd_pr__nfet_01v8__voff_slope_spectre=1
.param sky130_fd_pr__pfet_01v8_lvt__toxe_slope=0
.param sky130_fd_pr__pfet_01v8_lvt__vth0_slope=0
.param sky130_fd_pr__pfet_01v8_lvt__voff_slope=0
.param sky130_fd_pr__pfet_01v8_lvt__vth0_slope_spectre=1
.param sky130_fd_pr__pfet_01v8_lvt__voff_slope_spectre=1
.param mult=1

.include 'src/sim/sky130_ngspice.lib'
.include 'scene2/sim_NMCNR/pfet_01v8_alias_subckt.spice'
.include 'scene2/sim_NMCNR/NMCNR.cir'

VSS gnda 0 dc=0
VDD_SRC vdda_src 0 dc=1.8
VMEAS vdda_src vdda 0

VINN vinn 0 dc=0.6
VINP vinp 0 dc=0.6

XI1 gnda vdda vinn vinp vout Leung_NMCNR_Pin_3
CLOAD vout 0 2e-12

* Bias references for NMCNR (diode-connected NMOS)
* 参考 1：生成 VB3_ref（用于 VB3 偏置）
IREF3 vb3_ref gnda dc 1u
XREF3 vb3_ref vb3_ref gnda gnda sky130_fd_pr__nfet_01v8 L=0.95 W=1.08

* 参考 2：生成 VB4_ref（用于 VB4 偏置）
IREF4 vb4_ref gnda dc 1u
XREF4 vb4_ref vb4_ref gnda gnda sky130_fd_pr__nfet_01v8 L=0.95 W=1.08

* 将参考节点挂到子电路的 VB3/VB4 上
VVB3 VB3 vb3_ref dc 0
VVB4 VB4 vb4_ref dc 0

.op
.CONTROL
run
op
print i(vmeas) > Idc_1.txt
* PMOS 在子电路内：xi1.xm* 内层为 X1 (pfet_01v8_lvt)，路径 @m.xi1.xm*.X1.msky130_fd_pr__pfet_01v8_lvt
print @m.xi1.xm0.X1.msky130_fd_pr__pfet_01v8_lvt[vds]  @m.xi1.xm0.X1.msky130_fd_pr__pfet_01v8_lvt[vgs]  @m.xi1.xm0.X1.msky130_fd_pr__pfet_01v8_lvt[vth]  >  Op_1.txt
print @m.xi1.xm1.X1.msky130_fd_pr__pfet_01v8_lvt[vds]  @m.xi1.xm1.X1.msky130_fd_pr__pfet_01v8_lvt[vgs]  @m.xi1.xm1.X1.msky130_fd_pr__pfet_01v8_lvt[vth]  >> Op_1.txt
print @m.xi1.xm2.X1.msky130_fd_pr__pfet_01v8_lvt[vds]  @m.xi1.xm2.X1.msky130_fd_pr__pfet_01v8_lvt[vgs]  @m.xi1.xm2.X1.msky130_fd_pr__pfet_01v8_lvt[vth]  >> Op_1.txt
print @m.xi1.xm3.X1.msky130_fd_pr__pfet_01v8_lvt[vds]  @m.xi1.xm3.X1.msky130_fd_pr__pfet_01v8_lvt[vgs]  @m.xi1.xm3.X1.msky130_fd_pr__pfet_01v8_lvt[vth]  >> Op_1.txt
print @m.xi1.xm4.X1.msky130_fd_pr__pfet_01v8_lvt[vds]  @m.xi1.xm4.X1.msky130_fd_pr__pfet_01v8_lvt[vgs]  @m.xi1.xm4.X1.msky130_fd_pr__pfet_01v8_lvt[vth]  >> Op_1.txt
print @m.xi1.xm5.X1.msky130_fd_pr__pfet_01v8_lvt[vds]  @m.xi1.xm5.X1.msky130_fd_pr__pfet_01v8_lvt[vgs]  @m.xi1.xm5.X1.msky130_fd_pr__pfet_01v8_lvt[vth]  >> Op_1.txt
print @m.xi1.xm6.X1.msky130_fd_pr__pfet_01v8_lvt[vds]  @m.xi1.xm6.X1.msky130_fd_pr__pfet_01v8_lvt[vgs]  @m.xi1.xm6.X1.msky130_fd_pr__pfet_01v8_lvt[vth]  >> Op_1.txt
print @m.xi1.xm7.X1.msky130_fd_pr__pfet_01v8_lvt[vds]  @m.xi1.xm7.X1.msky130_fd_pr__pfet_01v8_lvt[vgs]  @m.xi1.xm7.X1.msky130_fd_pr__pfet_01v8_lvt[vth]  >> Op_1.txt
print @m.xi1.xm8.X1.msky130_fd_pr__pfet_01v8_lvt[vds]  @m.xi1.xm8.X1.msky130_fd_pr__pfet_01v8_lvt[vgs]  @m.xi1.xm8.X1.msky130_fd_pr__pfet_01v8_lvt[vth]  >> Op_1.txt
print @m.xi1.xm9.X1.msky130_fd_pr__pfet_01v8_lvt[vds]  @m.xi1.xm9.X1.msky130_fd_pr__pfet_01v8_lvt[vgs]  @m.xi1.xm9.X1.msky130_fd_pr__pfet_01v8_lvt[vth]  >> Op_1.txt
print @m.xi1.xm10.X1.msky130_fd_pr__pfet_01v8_lvt[vds] @m.xi1.xm10.X1.msky130_fd_pr__pfet_01v8_lvt[vgs] @m.xi1.xm10.X1.msky130_fd_pr__pfet_01v8_lvt[vth] >> Op_1.txt
print @m.xi1.xm11.X1.msky130_fd_pr__pfet_01v8_lvt[vds] @m.xi1.xm11.X1.msky130_fd_pr__pfet_01v8_lvt[vgs] @m.xi1.xm11.X1.msky130_fd_pr__pfet_01v8_lvt[vth] >> Op_1.txt
print @m.xi1.xm12.msky130_fd_pr__nfet_01v8[vds] @m.xi1.xm12.msky130_fd_pr__nfet_01v8[vgs] @m.xi1.xm12.msky130_fd_pr__nfet_01v8[vth] >> Op_1.txt
print @m.xi1.xm13.msky130_fd_pr__nfet_01v8[vds] @m.xi1.xm13.msky130_fd_pr__nfet_01v8[vgs] @m.xi1.xm13.msky130_fd_pr__nfet_01v8[vth] >> Op_1.txt
print @m.xi1.xm14.msky130_fd_pr__nfet_01v8[vds] @m.xi1.xm14.msky130_fd_pr__nfet_01v8[vgs] @m.xi1.xm14.msky130_fd_pr__nfet_01v8[vth] >> Op_1.txt
print @m.xi1.xm15.msky130_fd_pr__nfet_01v8[vds] @m.xi1.xm15.msky130_fd_pr__nfet_01v8[vgs] @m.xi1.xm15.msky130_fd_pr__nfet_01v8[vth] >> Op_1.txt
print @m.xi1.xm16.msky130_fd_pr__nfet_01v8[vds] @m.xi1.xm16.msky130_fd_pr__nfet_01v8[vgs] @m.xi1.xm16.msky130_fd_pr__nfet_01v8[vth] >> Op_1.txt
print @m.xi1.xm17.msky130_fd_pr__nfet_01v8[vds] @m.xi1.xm17.msky130_fd_pr__nfet_01v8[vgs] @m.xi1.xm17.msky130_fd_pr__nfet_01v8[vth] >> Op_1.txt
print @m.xi1.xm18.msky130_fd_pr__nfet_01v8[vds] @m.xi1.xm18.msky130_fd_pr__nfet_01v8[vgs] @m.xi1.xm18.msky130_fd_pr__nfet_01v8[vth] >> Op_1.txt
print @m.xi1.xm19.msky130_fd_pr__nfet_01v8[vds] @m.xi1.xm19.msky130_fd_pr__nfet_01v8[vgs] @m.xi1.xm19.msky130_fd_pr__nfet_01v8[vth] >> Op_1.txt
print @m.xi1.xm20.msky130_fd_pr__nfet_01v8[vds] @m.xi1.xm20.msky130_fd_pr__nfet_01v8[vgs] @m.xi1.xm20.msky130_fd_pr__nfet_01v8[vth] >> Op_1.txt
print @m.xi1.xm21.msky130_fd_pr__nfet_01v8[vds] @m.xi1.xm21.msky130_fd_pr__nfet_01v8[vgs] @m.xi1.xm21.msky130_fd_pr__nfet_01v8[vth] >> Op_1.txt
print @m.xi1.xm22.msky130_fd_pr__nfet_01v8[vds] @m.xi1.xm22.msky130_fd_pr__nfet_01v8[vgs] @m.xi1.xm22.msky130_fd_pr__nfet_01v8[vth] >> Op_1.txt
print @m.xi1.xm23.msky130_fd_pr__nfet_01v8[vds] @m.xi1.xm23.msky130_fd_pr__nfet_01v8[vgs] @m.xi1.xm23.msky130_fd_pr__nfet_01v8[vth] >> Op_1.txt
.ENDC
.END
