* Leung NMCNR OTA SR transient testbench（与 folded_AC 同序：.lib 再 .include alias 再 .include 电路；从项目根运行）
* 单独测试：cd 项目根后 ngspice -b scene2/sim_NMCNR/NMCNR_SR_pdk.cir

.option ngbehavior=ltpsa

.param sky130_fd_pr__nfet_01v8__toxe_slope=0
.param sky130_fd_pr__nfet_01v8__vth0_slope=0
.param sky130_fd_pr__nfet_01v8__voff_slope=0
.param sky130_fd_pr__nfet_01v8__toxe_slope_spectre=1
.param sky130_fd_pr__nfet_01v8__vth0_slope_spectre=1
.param sky130_fd_pr__nfet_01v8__voff_slope_spectre=1
.param sky130_fd_pr__pfet_01v8_lvt__toxe_slope=0
.param sky130_fd_pr__pfet_01v8_lvt__vth0_slope=0
.param sky130_fd_pr__pfet_01v8_lvt__voff_slope=0
.param sky130_fd_pr__pfet_01v8_lvt__vth0_slope_spectre=1
.param sky130_fd_pr__pfet_01v8_lvt__voff_slope_spectre=1
.param mult=1

.include 'src/sim/sky130_ngspice.lib'
* NMCNR 用 pfet_01v8，库只有 pfet_01v8_lvt
.include 'scene2/sim_NMCNR/pfet_01v8_alias_subckt.spice'
.include 'scene2/sim_NMCNR/NMCNR.cir'

* 3. 激励源
VSS gnda 0 dc=0
VDD vdda 0 dc=1.8
VIP vinp 0 dc=0.9 pulse(0.9 1.3 0 1p 1p 5u 10u)
VIN vinn 0 dc=0.9

XI1 gnda vdda vinn vinp vout Leung_NMCNR_Pin_3
CLOAD vout 0 2e-12

IREF3 vb3_ref gnda dc 1u
XREF3 vb3_ref vb3_ref gnda gnda sky130_fd_pr__nfet_01v8 L=0.95 W=1.08
IREF4 vb4_ref gnda dc 1u
XREF4 vb4_ref vb4_ref gnda gnda sky130_fd_pr__nfet_01v8 L=0.95 W=1.08
VVB3 VB3 vb3_ref dc 0
VVB4 VB4 vb4_ref dc 0

.tran 0.2n 2u
.CONTROL
run
wrdata SR_tran.txt time v(vout)
.ENDC
.END
